* =======================================================================
* Full SerDes Physical Layer Top-Level Integration
* TX -> Channel -> CTLE -> Sampler
*
* Process: CIC / TSMC 0.18um 1.8V CMOS
* Compatible with Synopsys HSPICE E-2010.12
*
* Python PRBS7 PWL Stimulus
* Analog Front-End:
*   CML Driver
*   Channel Termination
*   CTLE
*   StrongArm Sampler
* =======================================================================

* =======================================================================
* 1. Process Library
* =======================================================================

.lib 'cic018.l' TT

.option post=2
.option probe=1
.option ingold=2
.option accurate
.option method=gear

* =======================================================================
* 2. Power Supply
* =======================================================================

VDD VDD 0 DC 1.8V
VSS VSS 0 DC 0V

* =======================================================================
* 3. Python Generated PRBS7 Differential TX Input
*
* Generated by Python:
* stimulus.inc
*
* Contains:
* VIN_P
* VIN_N
*
* TX common mode = 0.9V
*
* =======================================================================

.include 'stimulus.inc'

* =======================================================================
* Sampling Clock
* 2.5GHz example clock
* =======================================================================

VCLK CLK 0 PULSE(
+0
+1.8
+0ps
+30ps
+30ps
+170ps
+400ps
)

* =======================================================================
* 4. TX CML Driver
* =======================================================================

X_TX_DRIVER
+ IN_P
+ IN_N
+ TX_OUT_P
+ TX_OUT_N
+ VDD
+ VSS
+ CML_DRIVER_BLOCK

.subckt CML_DRIVER_BLOCK vin_p vin_n vout_p vout_n vdd vss

M1 vout_n vin_p node_tail vss n_18
+ W=40u
+ L=0.18u

M2 vout_p vin_n node_tail vss n_18
+ W=40u
+ L=0.18u

M3 node_tail v_bias vss vss n_18
+ W=60u
+ L=0.36u
+ M=2

VBIAS_DRIVER v_bias 0 DC 0.75V

R1 vdd vout_p 200
R2 vdd vout_n 200

.ends CML_DRIVER_BLOCK

* =======================================================================
* 5. Channel + RX Termination
* =======================================================================

R_TERM_P TX_OUT_P V_CM 50
R_TERM_N TX_OUT_N V_CM 50

V_CM V_CM 0 DC 0.9V

C_ESD_P TX_OUT_P 0 100fF
C_ESD_N TX_OUT_N 0 100fF

* =======================================================================
* 6. CTLE Analog Equalizer
* =======================================================================

X_RX_CTLE
+ TX_OUT_P
+ TX_OUT_N
+ RX_CTLE_P
+ RX_CTLE_N
+ VDD
+ VSS
+ CTLE_BLOCK

.subckt CTLE_BLOCK vin_p vin_n vout_p vout_n vdd vss

M1 vout_n vin_p node_a vss n_18
+ W=30u
+ L=0.18u

M2 vout_p vin_n node_b vss n_18
+ W=30u
+ L=0.18u

M3 node_tail v_bias vss vss n_18
+ W=60u
+ L=0.36u
+ M=2

VBIAS_CTLE v_bias 0 DC 0.8V

Rs1 node_a node_tail 75
Rs2 node_b node_tail 75

Cs node_a node_b 100f

RL1 vdd vout_p 650
RL2 vdd vout_n 650

.ends CTLE_BLOCK

* =======================================================================
* 7. StrongArm Sampler
* =======================================================================

X_RX_SAMPLER
+ RX_CTLE_P
+ RX_CTLE_N
+ DOUT_P
+ DOUT_N
+ CLK
+ VDD
+ VSS
+ SAMPLER_BLOCK

.subckt SAMPLER_BLOCK vin_p vin_n dout_p dout_n clk vdd vss

M_TAIL node_tail clk vss vss n_18
+ W=16u
+ L=0.18u

M_IN1 node_l vin_p node_tail vss n_18
+ W=10u
+ L=0.18u

M_IN2 node_r vin_n node_tail vss n_18
+ W=10u
+ L=0.18u

M_N1 dout_n dout_p node_l vss n_18
+ W=8u
+ L=0.18u

M_N2 dout_p dout_n node_r vss n_18
+ W=8u
+ L=0.18u

M_P1 dout_n dout_p vdd vdd p_18
+ W=12u
+ L=0.18u

M_P2 dout_p dout_n vdd vdd p_18
+ W=12u
+ L=0.18u

M_RST1 dout_n clk vdd vdd p_18
+ W=6u
+ L=0.18u

M_RST2 dout_p clk vdd vdd p_18
+ W=6u
+ L=0.18u

M_RST3 node_l clk vdd vdd p_18
+ W=6u
+ L=0.18u

M_RST4 node_r clk vdd vdd p_18
+ W=6u
+ L=0.18u

.ends SAMPLER_BLOCK

* =======================================================================
* 8. Transient Simulation
* =======================================================================

.tran 1ps 200ns

* =======================================================================
* 9. Output Waveforms
* =======================================================================

.probe tran
+ v(IN_P)
+ v(IN_N)
+ v(TX_OUT_P,TX_OUT_N)
+ v(RX_CTLE_P,RX_CTLE_N)
+ v(CLK)
+ v(DOUT_P,DOUT_N)

* =======================================================================
* 10. Measurements
* =======================================================================

.meas tran V_CTLE_MAX
+ MAX v(RX_CTLE_P,RX_CTLE_N)
+ FROM=1ns
+ TO=64ns

.meas tran I_TOTAL_AVG
+ AVG i(VDD)
+ FROM=1ns
+ TO=64ns

.meas tran P_TOTAL_AVG
+ PARAM='1.8*abs(I_TOTAL_AVG)'

.end
